* SKY130 Two-Stage Miller OTA — NMOS input pair
* NMOS diff pair, PMOS mirror load, PMOS CS second stage
* Non-inverting from inp to out (inp on mirror side, inm on diode side)

.lib "sky130_models/sky130_ultra_minimal.lib.spice" tt

.options reltol=0.003 abstol=1e-12 vntol=1e-6

* Supply
Vdd vdd 0 1.8
Vss vss 0 0

* Input stimulus — differential AC
Vinp inp 0 DC 0.9 AC 0.5
Vinm inm 0 DC 0.9 AC -0.5

* === FIRST STAGE: NMOS diff pair + PMOS current mirror load ===

* Tail current source (NMOS, from VSS)
XM5 tail biasn vss vss sky130_fd_pr__nfet_01v8 W={W5}u L={L5}u nf=1

* Differential pair (NMOS) — inp drives M2 (mirror output side n2)
* inm drives M1 (diode side n1) for non-inverting response
XM1 n1 inm tail vss sky130_fd_pr__nfet_01v8 W={W1}u L={L1}u nf=1
XM2 n2 inp tail vss sky130_fd_pr__nfet_01v8 W={W1}u L={L1}u nf=1

* Active load (PMOS current mirror)
XM3 n1 n1 vdd vdd sky130_fd_pr__pfet_01v8 W={W3}u L={L3}u nf=1
XM4 n2 n1 vdd vdd sky130_fd_pr__pfet_01v8 W={W3}u L={L3}u nf=1

* === SECOND STAGE: PMOS common-source + NMOS current source load ===

XM6 out n2 vdd vdd sky130_fd_pr__pfet_01v8 W={W6}u L={L6}u nf=1
XM7 out biasn vss vss sky130_fd_pr__nfet_01v8 W={W7}u L={L7}u nf=1

* === Miller compensation (series Rc for RHP zero cancellation) ===
Cc out n2rc {Cc}p
Rc n2rc n2 {Rc}

* === Bias generation ===
* Current reference: VDD -> Ibias -> biasn -> NMOS diode to VSS
Ibias vdd biasn {Ibias}
XMbn biasn biasn vss vss sky130_fd_pr__nfet_01v8 W={Wbias}u L={Lbias}u nf=1

* === Load ===
CL out 0 5p

* === Measurements ===
.control
* Operating point
op

* Power measurement (scalar from OP)
let pwr = abs(v(vdd) * i(Vdd)) * 1e6
echo "RESULT_POWER_UW" $&pwr

* AC analysis — differential mode
ac dec 50 1 100Meg

* Write AC data immediately (before any alters)
wrdata ac_data v(out)

* DC gain
meas ac dc_gain_db find vdb(out) at=10
echo "RESULT_DC_GAIN_DB" $&dc_gain_db

* Save for CMRR
let saved_dcgain = dc_gain_db
set dcg_val = "$&saved_dcgain"

* GBW (0dB crossing)
meas ac gbw_hz when vdb(out)=0
echo "RESULT_GBW_HZ" $&gbw_hz

* Phase margin from vp() (backup — Python uses wrdata for proper unwrapped PM)
meas ac phase_at_gbw find vp(out) when vdb(out)=0
let pm_approx = 180 + phase_at_gbw
echo "RESULT_PHASE_MARGIN_DEG" $&pm_approx

* === CMRR: measure common-mode gain ===
alter Vinp ac = 1
alter Vinm ac = 1
ac dec 50 1 100Meg
meas ac cm_gain_db find vdb(out) at=10
let cmrr = $dcg_val - cm_gain_db
echo "RESULT_CMRR_DB" $&cmrr

* === Output swing: DC sweep with very coarse step ===
dc Vinp 0.4 1.4 0.1
meas dc vout_max max v(out)
meas dc vout_min min v(out)
let swing = vout_max - vout_min
echo "RESULT_OUTPUT_SWING_V" $&swing

echo "RESULT_DONE"
.endc

.end
