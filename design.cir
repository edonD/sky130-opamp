* SKY130 Folded Cascode OTA — NMOS input pair
* Single-stage high-gain topology with cascode output impedance

.lib "sky130_models/sky130_ultra_minimal.lib.spice" tt

.options reltol=0.003 abstol=1e-12 vntol=1e-6

* Supply
Vdd vdd 0 1.8
Vss vss 0 0

* Input stimulus
Vinp inp 0 DC 0.9 AC 0.5
Vinm inm 0 DC 0.9 AC -0.5

* === BIAS GENERATION ===
* Master bias current
Ibias vdd nbias {Ibias}
XMbn nbias nbias vss vss sky130_fd_pr__nfet_01v8 W={Wbn}u L={Lbn}u nf=1

* PMOS bias mirror
XMbp pbias pbias vdd vdd sky130_fd_pr__pfet_01v8 W={Wbp}u L={Lbp}u nf=1
XMbp2 pbias nbias vss vss sky130_fd_pr__nfet_01v8 W={Wbn}u L={Lbn}u nf=1

* NMOS cascode bias — stacked diodes for proper Vcasn
XMcn1 ncas_ref ncas_ref sn_ref vss sky130_fd_pr__nfet_01v8 W={Wcn}u L={Lcn}u nf=1
XMcn2 sn_ref nbias vss vss sky130_fd_pr__nfet_01v8 W={Wbn}u L={Lbn}u nf=1
Ibcn vdd ncas_ref {Ibias}

* PMOS cascode bias — stacked diodes for proper Vcasp
XMcp1 pcas_ref pcas_ref sp_ref vdd sky130_fd_pr__pfet_01v8 W={Wcp}u L={Lcp}u nf=1
XMcp2 sp_ref pbias vdd vdd sky130_fd_pr__pfet_01v8 W={Wbp}u L={Lbp}u nf=1
Ibcp pcas_ref vss {Ibias}

* === INPUT STAGE ===
* Tail current source (NMOS)
XMtail tail nbias vss vss sky130_fd_pr__nfet_01v8 W={Wtail}u L={Ltail}u nf=1

* NMOS differential pair
XM1 fp1 inp tail vss sky130_fd_pr__nfet_01v8 W={W1}u L={L1}u nf=1
XM2 fp2 inm tail vss sky130_fd_pr__nfet_01v8 W={W1}u L={L1}u nf=1

* === FOLDED CASCODE OUTPUT ===
* PMOS current sources (fold current into diff pair outputs)
XM3 fp1 pbias vdd vdd sky130_fd_pr__pfet_01v8 W={W3}u L={L3}u nf=1
XM4 fp2 pbias vdd vdd sky130_fd_pr__pfet_01v8 W={W3}u L={L3}u nf=1

* PMOS cascode devices
XM7 cm pcas_ref fp1 vdd sky130_fd_pr__pfet_01v8 W={W7}u L={L7}u nf=1
XM8 out pcas_ref fp2 vdd sky130_fd_pr__pfet_01v8 W={W7}u L={L7}u nf=1

* NMOS cascode devices
XM5 cm ncas_ref sn1 vss sky130_fd_pr__nfet_01v8 W={W5}u L={L5}u nf=1
XM6 out ncas_ref sn2 vss sky130_fd_pr__nfet_01v8 W={W5}u L={L5}u nf=1

* NMOS current sinks
XM9 sn1 nbias vss vss sky130_fd_pr__nfet_01v8 W={W9}u L={L9}u nf=1
XM10 sn2 nbias vss vss sky130_fd_pr__nfet_01v8 W={W9}u L={L9}u nf=1

* === Load ===
CL out 0 5p

.control
op

let pwr = abs(v(vdd) * i(Vdd)) * 1e6
echo "RESULT_POWER_UW" $&pwr

* AC analysis
ac dec 20 1 1G
wrdata {ac_file} v(out)

meas ac dc_gain_db find vdb(out) at=10
echo "RESULT_DC_GAIN_DB" $&dc_gain_db

let saved_dcgain = dc_gain_db
set dcg_val = "$&saved_dcgain"

meas ac gbw_hz when vdb(out)=0
echo "RESULT_GBW_HZ" $&gbw_hz

* CMRR
alter Vinp ac = 1
alter Vinm ac = 1
ac dec 10 1 1000
meas ac cm_gain_db find vdb(out) at=10
let cmrr = $dcg_val - cm_gain_db
echo "RESULT_CMRR_DB" $&cmrr

alter Vinp ac = 0.5
alter Vinm ac = -0.5

* Output swing
dc Vinp 0.4 1.4 0.2
meas dc vout_max max v(out)
meas dc vout_min min v(out)
let swing = vout_max - vout_min
echo "RESULT_OUTPUT_SWING_V" $&swing

echo "RESULT_DONE"
.endc

.end
