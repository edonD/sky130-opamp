* SKY130 Two-Stage Miller OTA — PMOS input pair
* PMOS input for higher intrinsic gain, NMOS current mirror load

.lib "sky130_models/sky130_ultra_minimal.lib.spice" tt

.options reltol=0.003 abstol=1e-12 vntol=1e-6

* Supply
Vdd vdd 0 1.8
Vss vss 0 0

* Input stimulus
Vinp inp 0 DC 0.9 AC 0.5
Vinm inm 0 DC 0.9 AC -0.5

* === BIAS GENERATION ===
Ibias vdd biasp {Ibias}
XMbp biasp biasp vdd vdd sky130_fd_pr__pfet_01v8 W={Wbp}u L={Lbp}u nf=1

* NMOS bias mirror
XMbn1 biasn biasn vss vss sky130_fd_pr__nfet_01v8 W={Wbn}u L={Lbn}u nf=1
XMbn2 biasn biasp vdd vdd sky130_fd_pr__pfet_01v8 W={Wbp}u L={Lbp}u nf=1

* === FIRST STAGE — PMOS diff pair with NMOS load ===
* Tail current source (PMOS)
XM5 tail biasp vdd vdd sky130_fd_pr__pfet_01v8 W={W5}u L={L5}u nf=1

* PMOS input pair
XM1 n1 inm tail vdd sky130_fd_pr__pfet_01v8 W={W1}u L={L1}u nf=1
XM2 n2 inp tail vdd sky130_fd_pr__pfet_01v8 W={W1}u L={L1}u nf=1

* NMOS current mirror load
XM3 n1 n1 vss vss sky130_fd_pr__nfet_01v8 W={W3}u L={L3}u nf=1
XM4 n2 n1 vss vss sky130_fd_pr__nfet_01v8 W={W3}u L={L3}u nf=1

* === SECOND STAGE ===
* NMOS common-source amplifier with PMOS current source load
XM6 out n2 vss vss sky130_fd_pr__nfet_01v8 W={W6}u L={L6}u nf=1
XM7 out biasp vdd vdd sky130_fd_pr__pfet_01v8 W={W7}u L={L7}u nf=1

* === Miller compensation ===
Rc n2 n2rc {Rc}
Cc n2rc out {Cc}p

* === Load ===
CL out 0 5p

.control
op

let pwr = abs(v(vdd) * i(Vdd)) * 1e6
echo "RESULT_POWER_UW" $&pwr

* AC analysis
ac dec 20 1 1G
wrdata {ac_file} v(out)

meas ac dc_gain_db find vdb(out) at=10
echo "RESULT_DC_GAIN_DB" $&dc_gain_db

let saved_dcgain = dc_gain_db
set dcg_val = "$&saved_dcgain"

meas ac gbw_hz when vdb(out)=0
echo "RESULT_GBW_HZ" $&gbw_hz

* CMRR
alter Vinp ac = 1
alter Vinm ac = 1
ac dec 10 1 1000
meas ac cm_gain_db find vdb(out) at=10
let cmrr = $dcg_val - cm_gain_db
echo "RESULT_CMRR_DB" $&cmrr

alter Vinp ac = 0.5
alter Vinm ac = -0.5

* Output swing
dc Vinp 0.4 1.4 0.2
meas dc vout_max max v(out)
meas dc vout_min min v(out)
let swing = vout_max - vout_min
echo "RESULT_OUTPUT_SWING_V" $&swing

echo "RESULT_DONE"
.endc

.end
